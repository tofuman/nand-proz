module NOT (A, Y);
input A;
output Y;

endmodule
