module NOR (A, B, Y);
input wire A,B;
output wire Y;

endmodule
