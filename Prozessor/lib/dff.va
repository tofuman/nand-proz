module DFF (D, Q, C);
input wire D,C;
output wire Q;

endmodule
